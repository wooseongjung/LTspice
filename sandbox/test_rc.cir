* RC lowpass — ngspice sanity test
* Expected: -3dB at ~159 Hz (fc = 1/(2*pi*R*C) = 1/(2*pi*1k*1u))

V1 in 0 AC 1 DC 0
R1 in out 1k
C1 out 0 1u

.ac dec 10 1 100k

.control
run
print v(out)
plot vdb(out)
.endc

.end
